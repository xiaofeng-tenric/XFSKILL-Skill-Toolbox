;============================================================
; XFSKILL Plugin: set_symbol_grid
; 根据两个引脚设置格点（带表单，类似 setgrid）
;   - 打开表单 → 依次点选两个引脚
;   - 间距 = 引脚距离 / 等分比（默认 2）
;   - X/Y 同步、原点 = 第一个引脚、应用到所有格点（均可关）
;
; 写法刻意贴近已验证能加载的 setgrid.il：
;   cond 用裸变量作测试；(times ...) 代替除法；不用多参数函数式记法
;============================================================

unless( boundp('xfskillPluginDir) xfskillPluginDir = nil)

; 记住本插件自己的目录：loader 会为每个插件重设 xfskillPluginDir，
; 多个插件共用这一个全局时，后加载的会覆盖先加载的，导致找不到自己的 .form
xfskill_set_symbol_grid_dir = xfskillPluginDir

; 表单句柄（单实例）
xfskill_set_symbol_grid_form = nil

; 引脚距离与第一脚坐标（设计单位），供 Apply/调整等分比时重算
xfskill_pin_dx = 0.0
xfskill_pin_dy = 0.0
xfskill_pin_x1 = 0.0
xfskill_pin_y1 = 0.0

;============================================================
; 入口：打开表单并依次选两个引脚
;============================================================
procedure( xfskill_set_symbol_grid()
  prog((gridForm formFile)
    when( xfskill_set_symbol_grid_form
      axlUIWExpose(xfskill_set_symbol_grid_form)
      return(t)
    )
    unless( xfskill_set_symbol_grid_dir
      axlMsgPut("XFSKILL: plugin directory unknown, cannot locate form")
      return(nil)
    )
    formFile = strcat(axlOSSlash(xfskill_set_symbol_grid_dir) "/set_symbol_grid.form")
    unless( isFile(formFile)
      axlMsgPut("XFSKILL: form file not found - %s" formFile)
      return(nil)
    )
    gridForm = axlFormCreate('xfskill_set_symbol_grid_form formFile nil
                             'xfskill_set_symbol_grid_action t nil)
    unless( gridForm
      axlMsgPut("XFSKILL: failed to create set_symbol_grid form")
      return(nil)
    )
    axlFormTitle(gridForm "XFSKILL - Set Grid by symbol")
    xfskill_set_symbol_grid_init(gridForm)
    axlFormDisplay(gridForm)
    xfskill_pick_two_pins(gridForm)
    t
  )
)

procedure( xfskill_set_symbol_grid_init(gridForm)
  axlFormSetField(gridForm "chk_syncxy" t)
  axlFormSetField(gridForm "chk_origin" t)
  axlFormSetField(gridForm "chk_all" t)
  axlFormSetField(gridForm "ratio_2" t)
  axlFormSetField(gridForm "pin1" "等待选择...")
  axlFormSetField(gridForm "pin2" "等待选择...")
)

; 依次点选两个引脚：用 axlSingleSelectPoint 逐个拾取（每次提示一个点），
; 比在同一命令里连调两次 axlSelect 更稳；坐标各自独立取，互不连累
procedure( xfskill_pick_two_pins(gridForm)
  prog((p1 p2)
    axlSetFindFilter(?enabled list("NOALL" "PINS") ?onButtons list("PINS"))

    axlClearSelSet()
    axlMsgPut("XFSKILL: 请点击第 1 个引脚")
    axlSingleSelectPoint()
    p1 = car(axlGetSelSet())
    unless( p1
      axlUIConfirm("未选到第一个引脚，已取消。")
      axlFormClose(gridForm)
      xfskill_set_symbol_grid_form = nil
      return(nil)
    )

    axlClearSelSet()
    axlMsgPut("XFSKILL: 请点击第 2 个引脚")
    axlSingleSelectPoint()
    p2 = car(axlGetSelSet())
    unless( p2
      axlUIConfirm("未选到第二个引脚，已取消。")
      axlFormClose(gridForm)
      xfskill_set_symbol_grid_form = nil
      return(nil)
    )

    ; 第 1 脚坐标（原点基准），独立取
    xfskill_pin_x1 = 0.0
    xfskill_pin_y1 = 0.0
    when( p1->xy
      xfskill_pin_x1 = xCoord(p1->xy)
      xfskill_pin_y1 = yCoord(p1->xy)
    )

    ; 两脚距离，独立取
    xfskill_pin_dx = 0.0
    xfskill_pin_dy = 0.0
    when( p2->xy
      xfskill_pin_dx = (abs (difference (xCoord p2->xy) xfskill_pin_x1))
      xfskill_pin_dy = (abs (difference (yCoord p2->xy) xfskill_pin_y1))
    )

    axlFormSetField(gridForm "pin1" sprintf(nil "(%g, %g)" xfskill_pin_x1 xfskill_pin_y1))
    axlFormSetField(gridForm "pin2" sprintf(nil "dx=%.4f  dy=%.4f" xfskill_pin_dx xfskill_pin_dy))
  )
)

;============================================================
; 应用：读表单选项，按 引脚距离/等分比 计算并写入格点
;============================================================
procedure( xfskill_set_symbol_grid_apply(gridForm)
  let((factor spacing grid hasDx hasDy)
    factor = xfskill_get_ratio_factor(gridForm)
    hasDx = (greaterp xfskill_pin_dx 0.0001)
    hasDy = (greaterp xfskill_pin_dy 0.0001)
    spacing = nil
    cond(
      (hasDx  (setq spacing (times xfskill_pin_dx factor)))
      (hasDy  (setq spacing (times xfskill_pin_dy factor)))
    )
    unless( spacing
      axlUIConfirm("引脚距离为 0，无法计算间距。")
      return(nil)
    )

    grid = axlDBGridGet("TOP")
    unless( grid
      axlMsgPut("XFSKILL: 无法读取格点设置")
      return(nil)
    )

    if( axlFormGetField(gridForm "chk_all") then
      grid->name = 'all
    else
      grid->name = 'etch
    )
    grid->xGrids = spacing
    when( axlFormGetField(gridForm "chk_syncxy")
      grid->yGrids = spacing
    )
    when( axlFormGetField(gridForm "chk_origin")
      grid->xOrigin = xfskill_pin_x1
      grid->yOrigin = xfskill_pin_y1
    )

    if( axlDBGridSet(grid) then
      axlUIConfirm(sprintf(nil "格点已设置  间距 %g  原点 (%g, %g)" spacing xfskill_pin_x1 xfskill_pin_y1))
    else
      axlUIConfirm("格点设置失败。")
    )
  )
)

; 等分比 → 乘法系数（避免除法）
procedure( xfskill_get_ratio_factor(gridForm)
  let((factor)
    factor = 0.5
    when( axlFormGetField(gridForm "ratio_3")  factor = 0.333333 )
    when( axlFormGetField(gridForm "ratio_4")  factor = 0.25 )
    factor
  )
)

;============================================================
; 表单回调
;============================================================
procedure( xfskill_set_symbol_grid_action(gridForm)
  case( gridForm->curField
    ("btn_ok"
      xfskill_set_symbol_grid_apply(gridForm)
      axlFormClose(gridForm)
      xfskill_set_symbol_grid_form = nil
    )
    ("btn_apply"
      xfskill_set_symbol_grid_apply(gridForm)
    )
    ("btn_cancel"
      axlFormClose(gridForm)
      xfskill_set_symbol_grid_form = nil
    )
  )
)

; 命令注册放在函数定义之后。interactive：需要交互点选两个引脚
axlCmdRegister("set_symbol_grid" `xfskill_set_symbol_grid ?cmdType "interactive")
